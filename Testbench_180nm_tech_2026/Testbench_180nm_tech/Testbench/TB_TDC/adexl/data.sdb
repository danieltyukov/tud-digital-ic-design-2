ADE simulation setup
Run mode: Single Run, Sweeps and Corners
Tests:
  Testbench:TB_TDC:1: Testbench/TB_TDC/schematic, simulator spectre
Global variables:
  delay = 30p
  supply = 1.8
