ADE simulation setup
Run mode: Single Run, Sweeps and Corners
Tests:
  Testbench:TB_TDC:1: Testbench/TB_TDC/schematic, simulator spectre
    Variables: m_inv_in = 19; m_inv_out = 1*m_inv_in; m_switch_t1 = 10; m_switch_t2 = m_switch_t1; mul = 11; trim_0_t1 = 1; trim_0_t2 = 1; trim_1_t1 = 1; trim_1_t2 = 1; trim_2_t1 = 1; trim_2_t2 = 0
Global variables:
  delay = 30p
  supply = 1.8
