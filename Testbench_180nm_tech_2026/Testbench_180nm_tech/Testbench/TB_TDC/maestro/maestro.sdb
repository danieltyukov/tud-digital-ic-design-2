ADE simulation setup
Run mode: Single Run, Sweeps and Corners
Tests:
  Testbench:TB_TDC:1: Testbench/TB_TDC/schematic, simulator spectre
    Variables: delay = 140p; m_inv_in = 10; m_inv_out = 1*m_inv_in; supply = 1.8; trim_0_t1 = 1.8; trim_0_t2 = 1.8; trim_1_t1 = 1.8; trim_1_t2 = 1.8; trim_2_t1 = 0; trim_2_t2 = 0; reset = 300p; trim0 = 2; trim1 = 20; trim2 = 21; fine = 18; fixt = 7; m1_t1 = 5; m1_t2 = 5; m2_t1 = 6; m2_t2 = 6; trim0_t2 = 2; trim1_t2 = 14; trim2_t2 = 18; start = 1n
    Outputs: (cross(VT("/out_t1") 0.9 1 "rising") - cross(VT("/in_t1") 0.9 1 "rising")); TAU1; TAU2
Global variables:
  delay = 30p
  supply = 1.8
