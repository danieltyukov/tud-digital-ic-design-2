ADE simulation setup
Test Testbench:TB_TDC:1: Testbench/TB_TDC/schematic, simulator spectre
  Models: /opt/ei/DK/tsmc/muse/BCDG2/2.16B_5M6_40K/tsmc18/../models/spectre/c018bcd_gen2_v1d6_usage.scs[pre_simu, tt_lib]
  Variables: m1_t1 = 5; m1_t2 = 5; m2_t1 = 6; m2_t2 = 6; fixt = 7; trim2 = 21; delay = 140p; supply = 1.8; trim_0_t1 = 1.8; trim_0_t2 = 1.8; trim_1_t1 = 1.8; trim_1_t2 = 1.8; trim_2_t1 = 0; trim_2_t2 = 0; reset = 300p; m_inv_in = 10; trim0 = 2; trim1 = 20; fine = 18; trim0_t2 = 2; trim1_t2 = 14; trim2_t2 = 18; start = 1n; m_inv_out = 1*m_inv_in
  Temperature: 27
  Analysis tran: stop=4n errpreset=conservative
  Output TAU1 = (cross(VT("/I7/I14/tau1") 0.9 1 "rising") - cross(VT("/I7/I14/start_in") 0.9 1 "rising"))
  Output TAU2 = (cross(VT("/I7/I14/tau2") 0.9 1 "rising") - cross(VT("/I7/I14/stop_in") 0.9 1 "rising"))
  Signals: /net7 as RESET, /net6 as START, /net5 as STOP, /Q1, /Q3, /Q4, /Q5, /Q6, /Q7, /Q8, /Q9, /Q10, /Q11, /Q12, /Q13, /Q14, /Q15, /Q16, /Q17, /Q18, /Q19, /Q20, /Q21, /Q22, /Q23, /Q24, /Q25, /Q26, /Q27, /Q28, /Q29, /Q30, /Q31, /I7/I14/tau2, /I7/I14/tau1, /I7/I14/start_in, /I7/I14/stop_in
Run mode: Single Run, Sweeps and Corners
Global variables:
  delay = 30p
  supply = 1.8
