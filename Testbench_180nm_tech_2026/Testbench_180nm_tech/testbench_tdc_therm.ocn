/* setsim */
simulator('spectre)

/* Version 1.1. added some more comment */
/* Version 1.0. Fixed some Boolean type errors. */
/* Version 0.3. Fixed initialization of "early" and "late" in INL calculation */

/*	Setup you parameters here
	Vdd is the Vdd voltage
	timeStep is the delay step for the parametric sweep
	transientSimTime is the transient simulation time for which the transient simulations are run
	startDelay is the offset, i.e. the first delay, for which the sweep is run
	corners is a list of all the corner which are run, normally: "tt" "ff" "ss" "snfp" "fnsp"
	you can omit a corner by deleting it from this list */

/* make sure you specify Vdd as a floating point number, so write "1.0" and not "1" */
Vdd = 1.8

/*
timestep should be approximately resolution / 5 for a fast simulation and
resolution / 20 for an accurate simulation
*/
timeStep = 0.5e-12

transientSimTime = 5e-9
startDelay = -15e-12

corners = `("tt" "ss")

earlyHigh = 1

desVar( "supply" Vdd)
/* Add more simulation Variables here, if needed */
desVar( "Cload" 8f)

/* Do not change anything below this line unless you know what you are doing !!! */

/* Setup the simulator */
design( "~/tsmcBCD/simulation/TB_TDC/spectre/schematic/netlist/netlist")
resultsDir( "~/tmp/")

/* The files for the output */
fout = outfile("~/simulation/results_tdc_therm.csv" "w")
flog = outfile("~/simulation/log_tdc_therm.txt" "w")

/* Only saves the important nodes and current */
printf("Debug line\n")
delete('save)
save( 'v "/Q1" "/Q2" "/Q3" "/Q4" "/Q5" "/Q6" "/Q7" "/Q8" "/Q9" "/Q10" "/Q11" "/Q12" "/Q13" "/Q14" "/Q15" "/Q16" "/Q17" "/Q18" "/Q19" "/Q20" "/Q21" "/Q22" "/Q23" "/Q24" "/Q25" "/Q26" "/Q27" "/Q28" "/Q29" "/Q30" "/Q31")
save('i "/I1/VDD" )
save( 'v "/VDD" )
temp( 27 )

/* Functions */
procedure( loadlibs( corner)
	alt_n_corner = if(corner=="snfp" "ss" corner)
	alt_n_corner = if(corner=="fnsp" "ff" alt_n_corner)
	alt_p_corner = if(corner=="snfp" "ff" corner)
	alt_p_corner = if(corner=="fnsp" "ss" alt_p_corner)
    modelFile(
	'("/opt/ei/DK/tsmc/oa180/mini018BCDG2/216A/models/spectre/c018bcd_gen2_v1d6_usage.scs" "pre_simu" "tt_lib" "ss_lib" "ff_lib" "fs_lib" "sf_lib" "mc_lib" "mismatch_lib")
	'("/opt/ei/DK/tsmc/oa180/mini018BCDG2/216A/models/spectre/c018bcd_gen2_v1d6.scs" "stat_noise")
	list("/opt/ei/DK/tsmc/oa180/mini018BCDG2/216A/models/spectre/c018bcd_gen2_v1d6.scs" corner)
	)
)

procedure( sampleOutputs()
	Out1 = value(v("Q1") transientSimTime)<Vmid
	Out2 = value(v("Q2") transientSimTime)<Vmid
	Out3 = value(v("Q3") transientSimTime)<Vmid
	Out4 = value(v("Q4") transientSimTime)<Vmid
	Out5 = value(v("Q5") transientSimTime)<Vmid
	Out6 = value(v("Q6") transientSimTime)<Vmid
	Out7 = value(v("Q7") transientSimTime)<Vmid
	Out8 = value(v("Q8") transientSimTime)<Vmid
	Out9 = value(v("Q9") transientSimTime)<Vmid
	Out10 = value(v("Q10") transientSimTime)<Vmid
	Out11 = value(v("Q11") transientSimTime)<Vmid
	Out12 = value(v("Q12") transientSimTime)<Vmid
	Out13 = value(v("Q13") transientSimTime)<Vmid
	Out14 = value(v("Q14") transientSimTime)<Vmid
	Out15 = value(v("Q15") transientSimTime)<Vmid
	Out16 = value(v("Q16") transientSimTime)<Vmid
	Out17 = value(v("Q17") transientSimTime)<Vmid
	Out18 = value(v("Q18") transientSimTime)<Vmid
	Out19 = value(v("Q19") transientSimTime)<Vmid
	Out20 = value(v("Q20") transientSimTime)<Vmid
	Out21 = value(v("Q21") transientSimTime)<Vmid
	Out22 = value(v("Q22") transientSimTime)<Vmid
	Out23 = value(v("Q23") transientSimTime)<Vmid
	Out24 = value(v("Q24") transientSimTime)<Vmid
	Out25 = value(v("Q25") transientSimTime)<Vmid
	Out26 = value(v("Q26") transientSimTime)<Vmid
	Out27 = value(v("Q27") transientSimTime)<Vmid
	Out28 = value(v("Q28") transientSimTime)<Vmid
	Out29 = value(v("Q29") transientSimTime)<Vmid
	Out30 = value(v("Q30") transientSimTime)<Vmid
	Out31 = value(v("Q31") transientSimTime)<Vmid
)

procedure( countOutputs()
	outcode = 0
	if( Out1 outcode++)
	if( Out2 outcode++)
	if( Out3 outcode++)
	if( Out4 outcode++)
	if( Out5 outcode++)
	if( Out6 outcode++)
	if( Out7 outcode++)
	if( Out8 outcode++)
	if( Out9 outcode++)
	if( Out10 outcode++)
	if( Out11 outcode++)
	if( Out12 outcode++)
	if( Out13 outcode++)
	if( Out14 outcode++)
	if( Out15 outcode++)
	if( Out16 outcode++)
	if( Out17 outcode++)
	if( Out18 outcode++)
	if( Out19 outcode++)
	if( Out20 outcode++)
	if( Out21 outcode++)
	if( Out22 outcode++)
	if( Out23 outcode++)
	if( Out24 outcode++)
	if( Out25 outcode++)
	if( Out26 outcode++)
	if( Out27 outcode++)
	if( Out28 outcode++)
	if( Out29 outcode++)
	if( Out30 outcode++)
	if( Out31 outcode++)

	outcode = if( earlyHigh!=0 31-outcode outcode)
)

procedure( checkThermometer()
	if( earlyHigh!=0 then
		if( !Out2 && Out1 MissingThermometer = 1)
		if( !Out3 && Out2 MissingThermometer = 1)
		if( !Out4 && Out3 MissingThermometer = 1)
		if( !Out5 && Out4 MissingThermometer = 1)
		if( !Out6 && Out5 MissingThermometer = 1)
		if( !Out7 && Out6 MissingThermometer = 1)
		if( !Out8 && Out7 MissingThermometer = 1)
		if( !Out9 && Out8 MissingThermometer = 1)
		if( !Out10 && Out9 MissingThermometer = 1)
		if( !Out11 && Out10 MissingThermometer = 1)
		if( !Out12 && Out11 MissingThermometer = 1)
		if( !Out13 && Out12 MissingThermometer = 1)
		if( !Out14 && Out13 MissingThermometer = 1)
		if( !Out15 && Out14 MissingThermometer = 1)
		if( !Out16 && Out15 MissingThermometer = 1)
		if( !Out17 && Out16 MissingThermometer = 1)
		if( !Out18 && Out17 MissingThermometer = 1)
		if( !Out19 && Out18 MissingThermometer = 1)
		if( !Out20 && Out19 MissingThermometer = 1)
		if( !Out21 && Out20 MissingThermometer = 1)
		if( !Out22 && Out21 MissingThermometer = 1)
		if( !Out23 && Out22 MissingThermometer = 1)
		if( !Out24 && Out23 MissingThermometer = 1)
		if( !Out25 && Out24 MissingThermometer = 1)
		if( !Out26 && Out25 MissingThermometer = 1)
		if( !Out27 && Out26 MissingThermometer = 1)
		if( !Out28 && Out27 MissingThermometer = 1)
		if( !Out29 && Out28 MissingThermometer = 1)
		if( !Out30 && Out29 MissingThermometer = 1)
		if( !Out31 && Out30 MissingThermometer = 1)
	)
	if( earlyHigh==0 then
		if( Out2 && !Out1 MissingThermometer = 1)
		if( Out3 && !Out2 MissingThermometer = 1)
		if( Out4 && !Out3 MissingThermometer = 1)
		if( Out5 && !Out4 MissingThermometer = 1)
		if( Out6 && !Out5 MissingThermometer = 1)
		if( Out7 && !Out6 MissingThermometer = 1)
		if( Out8 && !Out7 MissingThermometer = 1)
		if( Out9 && !Out8 MissingThermometer = 1)
		if( Out10 && !Out9 MissingThermometer = 1)
		if( Out11 && !Out10 MissingThermometer = 1)
		if( Out12 && !Out11 MissingThermometer = 1)
		if( Out13 && !Out12 MissingThermometer = 1)
		if( Out14 && !Out13 MissingThermometer = 1)
		if( Out15 && !Out14 MissingThermometer = 1)
		if( Out16 && !Out15 MissingThermometer = 1)
		if( Out17 && !Out16 MissingThermometer = 1)
		if( Out18 && !Out17 MissingThermometer = 1)
		if( Out19 && !Out18 MissingThermometer = 1)
		if( Out20 && !Out19 MissingThermometer = 1)
		if( Out21 && !Out20 MissingThermometer = 1)
		if( Out22 && !Out21 MissingThermometer = 1)
		if( Out23 && !Out22 MissingThermometer = 1)
		if( Out24 && !Out23 MissingThermometer = 1)
		if( Out25 && !Out24 MissingThermometer = 1)
		if( Out26 && !Out25 MissingThermometer = 1)
		if( Out27 && !Out26 MissingThermometer = 1)
		if( Out28 && !Out27 MissingThermometer = 1)
		if( Out29 && !Out28 MissingThermometer = 1)
		if( Out30 && !Out29 MissingThermometer = 1)
		if( Out31 && !Out30 MissingThermometer = 1)
	)
)

procedure( initializeSweep( corner)
	i = 0
	MissingThermometer = 0
	nonMonotonicity = 0
	total_energy = 0.0
	total_energy_count = 0
	old_outcode = 0
	lastchange_delay = 0.0
	missingCode = 0
	min_delay = 1.0
	max_delay = 0.0
	sum_delay = 0.0
	delay_count = 0
	outcode = 0

	fprintf( fout "%s corner\nDelay\tOutput\n" corner)
	fprintf( flog "%s corner\nDelay\tOutput\tEnergy\n" corner)

)

procedure( doRun()
	delay = i * timeStep + startDelay
	desVar( "delay" delay)
	desVar( "del" delay)
	run()
	selectResults('tran)

	integrate = abs(integ(i("/I1/VDD") 0 transientSimTime))
	energy = integrate * Vdd

	/* Read all the outputs and put them in Out1, Out2 ... Out31 */
	sampleOutputs()

	/* Generate the outputvalue and put it in outcode */
	countOutputs()

	/* Checks the thermometer code for missing bits, if so sets MissingThermometer */
	checkThermometer()

	/* Sum the energy over all runs + count (to calculate the average energy) */
	total_energy = total_energy + energy
	total_energy_count++

	/* Step change */
	if( (outcode > old_outcode) then

		/* Delay step, save delay time */
		this_delay = delay - lastchange_delay
		delays[outcode-1] = delay

		/* Check for missing codes, if so set missingCode to 1 */
		if( (outcode > (old_outcode + 1)) then
			missingCode = 1
		)

		/* If the outcode > 1 then we can use the delay step to update DNL finding
		   And to find the average delay (resolution) */
		if( (outcode > 1) then
			min_delay = if( (this_delay < min_delay) this_delay min_delay)
			max_delay = if( (this_delay > max_delay) this_delay max_delay)
			sum_delay = sum_delay + this_delay
			delay_count++
		)

		/* Print the step value and time to the output */
		fprintf( fout "%g\t%d\n" delay outcode)

		/* Remember the lastchange_delay to be able to find
           the delay step for the nex one */
		lastchange_delay = delay
	)

	/* Check for non-monotonicity */
	if( (outcode < old_outcode) then
		nonMonotonicity = 1
	)

	/* If there was a warning print it */
	if( (MissingThermometer == 1) then
		printf("WARNING - Missing bit in thermometer code at %g\n" delay)
		fprintf( fout "WARNING - Missing bit in thermometer code at %g\n" delay)
	)

	if( (missingCode == 1) then
		printf("WARNING - Missing code in output code at %g\n" delay)
		fprintf( fout "WARNING - Missing code in output code at %g\n" delay)
	)

	if( (nonMonotonicity == 1) then
		printf("WARNING - Non-monotonous output code at %g\n" delay)
		fprintf( fout "WARNING - Non-monotonous output code at %g\n" delay)
	)

	old_outcode = outcode

	/* Update the log */
	fprintf( flog "%g\t%d\t%g\n" delay outcode energy)

	/* Print status update to sumulation window */
	printf("===================================================================\n")
	printf("Outcode = %d\t\tDelay = %g\t\tCorner = %s\n" outcode delay corner)
	printf("===================================================================\n")
	/* increment the loop variable */
	++i
)

procedure( ok()
	(MissingThermometer+missingCode+nonMonotonicity)==0
)

procedure( calcINL()
	early = 0.0
	late = 0.0

	for( i 1 30
		cur_offset = delays[i] - delays[0] - i*resolution

		if( (cur_offset>late) then late=cur_offset)
		if( (cur_offset<early) then early=cur_offset)

	)

	(late - early)/(2*resolution)
)

procedure( generateOutputs()
	fprintf( fout "Simulation step_size\t%g\n" timeStep)
	fprintf( fout "Transient simulation time\t%g\n" transientSimTime)

	resolution = sum_delay / delay_count
	fprintf( fout "Resolution\t%g\n" resolution)

	DNL = max( max_delay-resolution resolution-min_delay)/resolution
	fprintf( fout "DNL\t%g\n" DNL)

	INL = calcINL()
	fprintf( fout "INL\t%g\n" INL)

	fprintf( fout "TDC Offset\t%g\n" delays[0]-resolution)

	energy_per_conversion = total_energy/total_energy_count
	fprintf( fout "Average Energy\t%g\n" energy_per_conversion)

	Q_DNL = -5*6.02+9.03+10*log10(1.0/12.0 + DNL*DNL/(2*3.2*3.2))
	THD = INL*INL/1024.0
	SINAD = -10.0*log10(10.0**(Q_DNL/10) + THD)
	ENOB = (SINAD - 1.76) / 6.02
	fprintf( fout "ENOB\t%g\n" ENOB)
	FoM = energy_per_conversion / (2**ENOB)
	fprintf( fout "FoM\t%g\n" FoM)
)

/* Last setups */
analysis( 'tran ?stop transientSimTime ?maxstep "1n")
Vmid = Vdd/2.0
declare( delays[31] )

/* Run the actual testbench */
foreach( corner corners
	loadlibs( corner)

	initializeSweep( corner)

	while( (outcode < 31)

		if( ok() doRun() outcode = 31)
	)
	/* if we get here, outcode should be 31, and/or ok() should be nil, MB */
	if( ok() then
		/* to get the energy right, continue simulating on the highest platform for a bit */
		j = i
		for( i j (j+j/31+5)
			if( ok() then
				doRun()
			)
		)
	)

	if( ok() then
			generateOutputs()
		else
			fprintf( fout "Errors occurred\n")
			printf("Errors occurred\n")
	)

	fprintf( fout "\n\n")
	fprintf( flog "\n\n")
)

close( flog)
close( fout)

exit
