ADE simulation setup
Test vernier2d_delay_tb_1: vernier2d/delay_tb/schematic, simulator spectre
  Models: /opt/ei/DK/tsmc/muse/BCDG2/2.16B_5M6_40K/tsmc18/../models/spectre/c018bcd_gen2_v1d6_usage.scs[pre_simu, ss_lib]
  Variables: m_inv_in = 2; mul = 1; m_switch_t2 = 1; trim_0_t1 = 0; trim_0_t2 = 0; trim_1_t1 = 0; trim_1_t2 = 0; trim_2_t1 = 0; trim_2_t2 = 0; m_switch_t1 = 1; m_load = 10; m_inv_out = 1*m_inv_in
  Temperature: 27
  Analysis tran: stop=2.5n errpreset=conservative
  Output TAU1 = (cross(VT("/out_t1") 0.9 1 "rising") - cross(VT("/in_t1") 0.9 1 "rising"))
  Output TAU2 = (cross(VT("/out_t2") 0.9 1 "rising") - cross(VT("/in_t2") 0.9 1 "rising"))
  Signals: /START, /in_t1, /out_t1, /out_t2, /in_t2
Run mode: Single Run, Sweeps and Corners
Setup values for test vernier2d_delay_tb_1: m_inv_in = {Inclusion List}2{Inclusion List}{From/To}Linear:2:2:34{From/To}
