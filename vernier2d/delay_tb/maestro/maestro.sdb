ADE simulation setup
Run mode: Single Run, Sweeps and Corners
Tests:
  vernier2d_delay_tb_1: vernier2d/delay_tb/schematic, simulator spectre
    Variables: m_switch_t1 = 1; m_switch_t2 = 1; trim_0_t1 = 0; trim_0_t2 = 0; trim_1_t1 = 0; trim_1_t2 = 0; trim_2_t1 = 0; trim_2_t2 = 0; mul = 1; m_inv_in = 4; m_inv_out = 16; m_load = 30
