ADE simulation setup
Test vernier2d_delay_tb_1: vernier2d/delay_tb_withSR/schematic, simulator spectre
  Models: /opt/ei/DK/tsmc/muse/BCDG2/2.16B_5M6_40K/tsmc18/../models/spectre/c018bcd_gen2_v1d6_usage.scs[pre_simu, ff_lib]
  Variables: m_switch_t1 = 10; trim_0_t1 = 1; trim_0_t2 = 0; trim_1_t1 = 1; trim_1_t2 = 0; trim_2_t1 = 1; trim_2_t2 = 1; m_load = 22; mul = 11; m_inv_in = 19; m_switch_t2 = m_switch_t1; m_inv_out = 1*m_inv_in
  Temperature: 27
  Analysis tran: stop=2.5n errpreset=conservative
  Output TAU1 = (cross(VT("/out_t1") 0.9 1 "rising") - cross(VT("/in_t1") 0.9 1 "rising"))
  Output TAU2 = (cross(VT("/out_t2") 0.9 1 "rising") - cross(VT("/in_t2") 0.9 1 "rising"))
  Signals: /START, /in_t1, /out_t1, /out_t2, /in_t2
Run mode: Single Run, Sweeps and Corners
