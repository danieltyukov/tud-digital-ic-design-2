ADE simulation setup
Run mode: Single Run, Sweeps and Corners
Tests:
  vernier2d_delay_tb_1: vernier2d/delay_tb_withSR/schematic, simulator spectre
    Variables: m_switch_t1 = 10; m_switch_t2 = m_switch_t1; trim_0_t1 = 1; trim_0_t2 = 0; trim_1_t1 = 1; trim_1_t2 = 0; trim_2_t1 = 1; trim_2_t2 = 1; mul = 11; m_inv_in = 19; m_inv_out = 1*m_inv_in; m_load = 22
    Outputs: TAU1; TAU2
