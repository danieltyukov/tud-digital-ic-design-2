ADE simulation setup
Run mode: Single Run, Sweeps and Corners
Tests:
  vernier2d_srlatch_tb_1: vernier2d/srlatch_tb/schematic, simulator spectre
    Variables: tdr = 300p; tds = 200p
