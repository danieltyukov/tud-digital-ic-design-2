ADE simulation setup
Test vernier2d_srlatch_tb_1: vernier2d/srlatch_tb/schematic, simulator spectre
  Models: /opt/ei/DK/tsmc/muse/BCDG2/2.16B_5M6_40K/tsmc18/../models/spectre/c018bcd_gen2_v1d6_usage.scs[pre_simu, tt_lib]
  Variables: tdr = 300p; tds = 200p
  Temperature: 27
  Analysis tran: stop=600p
  Signals: /net5
Run mode: Single Run, Sweeps and Corners
