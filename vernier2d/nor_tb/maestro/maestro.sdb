ADE simulation setup
Run mode: Single Run, Sweeps and Corners
Tests:
  vernier2d_nor_tb_1: vernier2d/nor_tb/schematic, simulator spectre
