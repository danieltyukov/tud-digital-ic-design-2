ADE simulation setup
Test vernier2d_nor_tb_1: vernier2d/nor_tb/schematic, simulator spectre
  Models: /opt/ei/DK/tsmc/muse/BCDG2/2.16B_5M6_40K/tsmc18/../models/spectre/c018bcd_gen2_v1d6_usage.scs[pre_simu, tt_lib]
  Temperature: 27
  Analysis tran: stop=5u errpreset=conservative
  Signals: /out, /net2, /net1
Run mode: Single Run, Sweeps and Corners
