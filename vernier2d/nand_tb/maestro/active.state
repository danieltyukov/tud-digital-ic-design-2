ADE simulation setup
Test vernier2d_nand_tb_1: vernier2d/nand_tb/schematic, simulator spectre
  Models: /opt/ei/DK/tsmc/muse/BCDG2/2.16B_5M6_40K/tsmc18/../models/spectre/c018bcd_gen2_v1d6_usage.scs[pre_simu, tt_lib]
  Temperature: 27
  Analysis tran: stop=10u errpreset=conservative
  Signals: /net3 as OUT, /net2 as A, /net1 as B
Run mode: Single Run, Sweeps and Corners
