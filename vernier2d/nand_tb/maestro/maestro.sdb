ADE simulation setup
Run mode: Single Run, Sweeps and Corners
Tests:
  vernier2d_nand_tb_1: vernier2d/nand_tb/schematic, simulator spectre
