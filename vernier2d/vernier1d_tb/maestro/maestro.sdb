ADE simulation setup
Run mode: Single Run, Sweeps and Corners
Tests:
  vernier2d_vernier1d_tb_1: vernier2d/vernier1d_tb/schematic, simulator spectre
