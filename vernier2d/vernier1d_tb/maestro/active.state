ADE simulation setup
Test vernier2d_vernier1d_tb_1: vernier2d/vernier1d_tb/schematic, simulator spectre
  Models: /opt/ei/DK/tsmc/muse/BCDG2/2.16B_5M6_40K/tsmc18/../models/spectre/c018bcd_gen2_v1d6_usage.scs[pre_simu, tt_lib]
  Temperature: 27
  Analysis tran: stop=5m
  Signals: /net5, /net6, /net7, /net8, /net9, /net10, /net11, /net12
Run mode: Single Run, Sweeps and Corners
