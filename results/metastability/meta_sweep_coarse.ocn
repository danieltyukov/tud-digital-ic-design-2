; Metastability characterization of vernier2d/srlatch (TDC arbiter), coarse pass.
; S edge fixed at 200p (tds); R edge at 200p+dt (tdr). dt>0 -> S leads -> Q fires.
; Measures final Q/QB and the Q rising-edge crossing time (decision latency).
simulator( 'spectre )
design( "vernier2d" "srlatch_tb" "schematic" )
resultsDir( "/home/datyukov/sims/srlatch_meta" )
modelFile(
  '("/opt/ei/DK/tsmc/muse/BCDG2/2.16B_5M6_40K/models/spectre/c018bcd_gen2_v1d6_usage.scs" "pre_simu")
  '("/opt/ei/DK/tsmc/muse/BCDG2/2.16B_5M6_40K/models/spectre/c018bcd_gen2_v1d6_usage.scs" "tt_lib")
)
analysis( 'tran ?stop "1.5n" ?errpreset "conservative" ?maxstep "2p" )
temp( 27 )
save( 'v "/net1" "/net2" "/net3" "/net5" "/net6" )

Vdd = 1.8
tbase = 200e-12
tmeas = 1.45e-9

fout = outfile( "/home/datyukov/sims/srlatch_meta/meta_coarse.csv" "w" )
fprintf( fout "dt_s,q_final_V,qb_final_V,tq_cross_s\n" )

foreach( dtps '( -20.0 -10.0 -5.0 -2.0 -1.0 -0.5 -0.2 -0.1 -0.05 -0.02 0.0 0.02 0.05 0.1 0.2 0.5 1.0 2.0 5.0 10.0 20.0 )
  dt = dtps * 1e-12
  desVar( "tds" tbase )
  desVar( "tdr" tbase + dt )
  run()
  selectResult( 'tran )
  qf  = value( v("net5") tmeas )
  qbf = value( v("net6") tmeas )
  tq  = cross( v("net5") Vdd/2.0 1 "rising" )
  if( tq == nil then tq = -1.0 )
  fprintf( fout "%.15g,%.6f,%.6f,%.15g\n" dt qf qbf tq )
  fprintf( poport "PT dt=%gps qf=%.3f qbf=%.3f tq=%.5gs\n" dtps qf qbf tq )
)
close( fout )
fprintf( poport "META_COARSE_DONE\n" )
exit()
